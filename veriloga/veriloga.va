// VerilogA for RRAM_PUF, RRAM, veriloga
`include "constants.vams"
`include "disciplines.vams"

module RRAM(p,n,VR);
inout p,n,VR;
electrical p,n,gnd,VR;
parameter real Ron=1000;
real Roff=2e4;
real Roffr;
parameter real Vset=0.8;   //unit V
parameter real Vreset= 0.8;   //unit V 0.92
parameter real Vforming=2.9;   //unit V

real time_of_on;    //
real time_of_off;
real R;
parameter integer seed_HRS= 1 from [1:30];
integer seed_LRS;
parameter integer seed_RCR= 1 from [1:30];
real random_HRS;
real random_LRS;

real flag_on;
integer print;
real time_scale;
real positive;
integer par;
real parn;
integer int1;
integer int2;
integer int3;

real dt;
real resistance_change_rate1=0.25e13;
real resistance_change_rate2=0.25e13;

   analog begin
   @(initial_step)  begin
    R=1e3;   //1G ohm
    //seed=23;
    if (1) begin
  		par = 100;
		R=Ron;
       time_of_on=$abstime;
       flag_on=-1;
       seed_LRS = 1;

       random_LRS =$rdist_normal(seed_LRS,1,0.1);
	   positive = 1;
	   while(positive) begin
			if(random_LRS > 0.5) begin
				positive = 0;
			end
			else begin
				random_LRS =1;
			end
	   end
	   dt = 2.2e-7;//$rdist_normal(seed_LRS,2.41e-07,7.7e-08);
	   positive = 1;
	   while(positive) begin
			if(dt > 0) begin
				positive = 0;
			end
			else begin
				dt =$rdist_normal(seed_LRS,1,0.1);
			end
	   end
	  // Vreset = $rdist_normal(seed_LRS,0.9160,0.0429);
		Roff = 5.5478e4;//$rdist_normal(seed_LRS,3.4166e+04,2.5739e+04);
	    positive = 1;
	   while(positive) begin
			if(Roff > 0) begin
				positive = 0;
			end
			else begin
				Roff =$rdist_normal(seed_LRS,1,0.1);
			end
	   end
		resistance_change_rate1 = 0.2*Roff/dt;
		resistance_change_rate2 = 0.8*Roff/dt;
         $strobe("forming success",seed_LRS,random_LRS,dt,Vreset,Roff,Ron);
       // $strobe("forming success");
    end

    else begin
        R=1e3;
         $strobe("forming failed");
    end
    // $strobe("R_initial",R);

   //$strobe("resistance_change_rate",resistance_change_rate);
   end
//

 // V(Vrandom)<+random;
//
  @(cross(V(n,p)-Vreset,+1)) begin     // voltage cross Vreset

     time_of_off=$abstime;
      flag_on=0;                       //represent high resistance
      //random_HRS =$rdist_normal(seed_HRS,1,0.3);

      //R=Roff*random_HRS;

     //if (R<1e4) begin
          //R=1e3;
    // end
    // if (R>1e8) begin
        // R=1e8;
     //end
 //$strobe("R",R);
// $strobe("reset success",time_of_off, time_of_on,time_scale,$abstime);
  print=1;
         // $strobe("R",R);
	$strobe("reset success",time_of_off,V(n,p),Vreset);
  end

    @(cross(V(p,n)-Vset,+1)) begin                 //else if  (V(p,n)>=Vset)  begin
       time_of_on=$abstime;
      flag_on=1;
		if(par == 100) begin
		//par = $cds_get_mc_trial_number();
		//$strobe("par",par);
		//parn=$rdist_normal(par,1,0.1);
		//$strobe("par",par,parn);

		int1 = time_of_on*1e14%10000000;
	//	$strobe("random_LRS11",time_of_on,int1,random_LRS);
	//	int = par;
     random_LRS =$rdist_normal(int1,1,0.1);
	//	$strobe("random_LRS12",time_of_on,int1,random_LRS);
	   positive = 1;
	   while(positive) begin
			if(random_LRS > 0.7) begin
				positive = 0;
			end
			else begin
				random_LRS =1;
			end
	   end
		int2 = time_of_off*1e14%10000000;
	   dt = $rdist_normal(int2,8.41e-07,7.7e-08);
	//	$strobe("dt",time_of_off,int,dt);
	   positive = 1;
	   while(positive) begin
			if(dt > 0) begin
				positive = 0;
			end
			else begin
				dt =8.41e-07;
			end
	   end
	  // Vreset = $rdist_normal(seed_LRS,0.9160,0.0429);
		int3 = time_scale*1e14%10000000;
		$strobe("Roff",time_scale,int3,Roff);
		Roff = 3.4166e+04;//$rdist_normal(int3,3.4166e+04,2.5739e+04);
		$strobe("Roff",time_scale,int3,Roff);
	    positive = 1;
	   while(positive) begin
			if(Roff > 1000 & Roff<5e6 ) begin   //Roff > 100 & Roff < 1e6
				//int1 = time_of_on*1e9%10;
	//			$strobe("true Roff1",Roff);
				//Roff =$rdist_normal(seed_LRS,1,0.1);
				//$strobe("true Roff2",Roff);
				//Roff =$rdist_normal(seed_LRS,1,0.1);
				//$strobe("true Roff3",Roff);
				positive = 0;
			end
			else begin
				$strobe("wrong Roff",Roff);
				Roff =3e4;
	//			$strobe("Roff2",Roff);
			end
	   end
		par = 1;
	end
	else begin
	//	$strobe("random_LRS1",time_of_on,int1,random_LRS);
     random_LRS =$rdist_normal(int1,1,0.1);
	//	$strobe("random_LRS2",time_of_on,int1,random_LRS);
	   positive = 1;
	   while(positive) begin
			if(random_LRS > 0.7) begin
				positive = 0;
			end
			else begin
				random_LRS =1;
			end
	   end

	   dt = $rdist_normal(int2,8.41e-07,7.7e-08);
	   positive = 1;
	   while(positive) begin
			if(dt > 0) begin
				positive = 0;
			end
			else begin
				dt =8.41e-07;
			end
	   end

	//	$strobe("Roff",time_scale,int3,Roff);
		Roff = 3.4166e+04;//$rdist_normal(int3,3.4166e+04,2.5739e+04);
	    positive = 1;
	   while(positive) begin
			if(Roff > 1000 & Roff<5e6) begin   //Roff > 100 & Roff < 1e6
				//int1 = time_of_on*1e9%10;
				positive = 0;
			end
			else begin
				$strobe("wrong Roff",Roff);
				Roff =3e4;
			end
	   end
		par = par + 1;
	end
//	$strobe("num",par);
		resistance_change_rate1 = Roff/dt;
     //R=Ron*random_LRS;
    // if (R<50) begin
          //R=50;
     //end
    // if (R>5e5) begin
       //  R=5e5;
     //end
       // $strobe("R",R);
    // $strobe("Ron",R);
   //   $strobe("set success",random_LRS,dt,Roff);
  end

  if (flag_on==1) begin
     time_scale=$abstime-time_of_on;
     if (R>=(Ron*random_LRS))
     begin
        R=Roffr-time_scale*resistance_change_rate1;
     end
     if (R<(Ron*random_LRS))
     begin
         R=Ron*random_LRS;
     end
      //$strobe("R",R);
  end

  if (flag_on == 0) begin
     time_scale=$abstime-time_of_off;
     if (R<=(Roff))
     begin
        if(time_scale<0.7*dt)
			begin
				R=Ron*random_LRS+time_scale*resistance_change_rate1;
			end
		if(time_scale>=0.7*dt)
			begin
				R=Ron*random_LRS+0.7*dt*resistance_change_rate1+(time_scale-0.7*dt)*resistance_change_rate2;
		end
     end
     if (R>(Roff))
     begin
         R=Roff;
     end
   //  $strobe("R",R);

   end

  V(p,n)<+I(p,n)*R;
  V(VR)<+R;

  if (print==1) begin

      print=0;
  end

  end
endmodule
